// SPDX-License-Identifier: SHL-2.1
// SPDX-FileCopyrightText: 2024 RVLab Contributors

// Cache hit rates?
// Other config? -> Prefetch buffer etc

{
  name: "ddr_ctrl"
  clock_primary: "sys_clk"
  bus_device: "tlul"
  regwidth: "32"
  registers: [
    {
      name: "status"
      desc: "DDR status"
      swaccess: "ro"
      hwaccess: "hwo"
      hwext: "true"
      fields: [
        {bits: "0", name: "present", desc: "DDR Controller present"}
        {bits: "1", name: "calib_complete", desc: "DDR initial calibration complete"}
        {bits: "6:2", name: "calib_status", desc: "DDR internal calibration state"}
      ]
    }  
    {
      name: "ctrl"
      desc: "Control"
      swaccess: "rw"
      hwaccess: "hro"
      fields: [
        {bits: "0", name: "rst_n", resval: "0", desc: "UberDDR3 reset (active low)"}
        {bits: "1", name: "self_refresh", resval: "0", desc: "DDR3 Self Refresh Enable"}
      ]
    },
  ]
}
